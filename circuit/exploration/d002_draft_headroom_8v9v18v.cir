* ocd_v1p4_v0p3_hybrid_draft: OCD-style overdrive v0.1 (unbranded), v1.4-style hybrid draft (S002+S003 cross-checked with S001/S013). 8-18V DC. TRUE BYPASS external. SIMULATION-ONLY/UNVERIFIED: provisional values, clipping wiring TBD/conflict, APPROX models. DC-op debug pass applied (bias/Vref stiffness/clipping DC-safe placeholders) - still provisional, do not fabricate.
* Generated by circuit-design-skill.
* Models: vendor models supplied.
* Provenance is recorded per model below.

* --- device models ---
* model provenance: vendor=Texas Instruments; part=TL082 (macromodel); file=../models/TL082.301; sha256=adad2e131f728610963e0797670ea34d2857c0b26b3f49c6ce356a3213d89011; source=TI SLOJ070 / https://www.ti.com/lit/zip/sloj070 (accessed 2026-11-09)
.SUBCKT TL082    1 2 3 4 5
*
  C1   11 12 3.498E-12
  C2    6  7 15.00E-12
  DC    5 53 DX
  DE   54  5 DX
  DLP  90 91 DX
  DLN  92 90 DX
  DP    4  3 DX
  EGND 99  0 POLY(2) (3,0) (4,0) 0 .5 .5
  FB    7 99 POLY(5) VB VC VE VLP VLN 0 4.715E6 -5E6 5E6 5E6 -5E6
  GA    6  0 11 12 282.8E-6
  GCM   0  6 10 99 8.942E-9
  ISS   3 10 DC 195.0E-6
  HLIM 90  0 VLIM 1K
  J1   11  2 10 JX
  J2   12  1 10 JX
  R2    6  9 100.0E3
  RD1   4 11 3.536E3
  RD2   4 12 3.536E3
  RO1   8  5 150
  RO2   7 99 150
  RP    3  4 2.143E3
  RSS  10 99 1.026E6
  VB    9  0 DC 0
  VC    3 53 DC 2.200
  VE   54  4 DC 2.200
  VLIM  7  8 DC 0
  VLP  91  0 DC 25
  VLN   0 92 DC 25
.MODEL DX D(IS=800.0E-18)
.MODEL JX PJF(IS=15.00E-12 BETA=270.1E-6 VTO=-1)
.ENDS
* model provenance: vendor=project approximation; part=2N7000 (APPROX, exploration only); file=../models/APPROX_2N7000.lib; sha256=081054dff4a75cb511fef93cd2e8c4310a685018b570eb92f2f241bc9b992a55; source=local APPROX file; NOT manufacturer model; see circuit/models/PROVENANCE.md
.SUBCKT APPROX_2N7000 D G S
M1 D G S S NMOS2N7000
.MODEL NMOS2N7000 NMOS (VTO=2.1 KP=0.05 LAMBDA=0.02 RD=1 RS=1 CBD=20p CBS=20p IS=1e-14)
* Body diode D-S behavior is critical in OCD topology; this approximation is rough.
DBODY S D DBODY2N7
.MODEL DBODY2N7 D (IS=1e-9 N=1.6 RS=0.5 CJO=20p)
.ENDS APPROX_2N7000
* model provenance: vendor=project approximation; part=BAT46-class (APPROX, exploration only); file=../models/APPROX_BAT46.lib; sha256=7b617c80cc7481ad33ce728db7e09b1860f1bb6143f9c8701b954c6616e295b3; source=local APPROX file; NOT manufacturer model; D003 default option
.MODEL APPROX_BAT46 D (IS=0.1u RS=2 N=1.05 BV=100 IBV=1u CJO=10p)

* --- circuit ---
V1 VCC 0 DC 9
V_IN IN_SIG 0 SIN(0 50m 1k)
R_V1 VCC VREF 10k
R_V2 VREF 0 10k
C_VREF VREF 0 10u
C_IN IN_SIG IN_A 22n
R_IN_BIAS IN_A VREF 1Meg
XU1A IN_A G1_FB VCC 0 G1_OUT TL082
R_G1 G1_FB VREF 2.2k
R_G1F G1_FB DRV_W 18k
R_DRV_MID DRV_W G1_OUT 500k
C_G1HF G1_OUT G1_FB 220p
R_CLIP G1_OUT CLIP_NODE 10k
C_CLIP_HF CLIP_NODE VREF 100n
R_CLIP_BIAS CLIP_NODE VREF 100k
XQ1 CLIP_NODE CLIP_NODE VREF APPROX_2N7000
XQ2 VREF VREF ASYM_NODE APPROX_2N7000
D_ASYM ASYM_NODE CLIP_NODE APPROX_BAT46
R_ASYM ASYM_NODE VREF 1Meg
XU1B CLIP_NODE G2_FB VCC 0 G2_OUT TL082
R_G2 G2_FB VREF 10k
R_G2F G2_FB G2_OUT 39k
R_TONE G2_OUT TONE_NODE 10k
C_TONE TONE_NODE 0 47n
C_OUT TONE_NODE VOL_TOP 1u
R_VOL VOL_TOP VOUT 50k
R_VOLG VOUT 0 50k
R_LOAD VOUT 0 100k

.control
set noaskquit
echo "DRAFT_HEADROOM_8V9V18V sim_only=1 provisional=1 APPROX_models=1"
foreach vv 8 9 18
  alter V1 dc=$vv
  tran 10u 30m
  meas tran vrefm MAX v(vref) from=10m to=30m
  meas tran vrefn MIN v(vref) from=10m to=30m
  meas tran g1m MAX v(g1_out) from=10m to=30m
  meas tran g1n MIN v(g1_out) from=10m to=30m
  meas tran clm MAX v(clip_node) from=10m to=30m
  meas tran cln MIN v(clip_node) from=10m to=30m
  meas tran g2m MAX v(g2_out) from=10m to=30m
  meas tran g2n MIN v(g2_out) from=10m to=30m
  meas tran vom MAX v(vout) from=10m to=30m
  meas tran von MIN v(vout) from=10m to=30m
  echo "===VCC=$vv==="
  print vrefm vrefn g1m g1n clm cln g2m g2n vom von
end
quit
.endc
.end
