* D002 v2 - TL082 single-supply Vref bias check (EXPLORATION ONLY, model/setup must be interpreted cautiously)
* TI TL082.301 (SLOJ070) subckt: 1=noninv 2=inv 3=V+ 4=V- 5=out
VCC vcc 0 DC 9
R1 vcc vref 100k
R2 vref 0 100k
Cref vref 0 10u
Vin in vref DC 0 SIN(0 10m 1k)
Rg in fb 2.2k
Rf fb out 100k
XU1 in fb vcc 0 out TL082
Rload out 0 100k
.include ../models/TL082.301
.op
.tran 10u 5m
.control
set noaskquit
foreach vv 5 9 18
  alter @VCC[dc] = $vv
  op
  echo "===VCC=$vv==="
  print v(vcc) v(vref) v(out)
  tran 10u 5m
  meas tran vmax MAX v(out) from=1m to=5m
  meas tran vmin MIN v(out) from=1m to=5m
  print vmax vmin
end
.endc
.end
