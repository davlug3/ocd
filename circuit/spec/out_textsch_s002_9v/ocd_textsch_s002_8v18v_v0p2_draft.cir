* ocd_textsch_s002_8v18v_v0p2_draft: OCD-style overdrive draft from S002-verified topology + user node connections. Supply 8-18V DC center-negative, 9V nominal test. Clip wiring confirmed from S002 image. Op-amp feedback wiring assumed. Not a verified Fulltone netlist. Do not fabricate.
* Generated by circuit-design-skill.
* Models: vendor models supplied.
* Provenance is recorded per model below.

* --- device models ---
* model provenance: vendor=Texas Instruments; part=TL082 (macromodel); file=../models/TL082.301; sha256=adad2e131f728610963e0797670ea34d2857c0b26b3f49c6ce356a3213d89011; source=TI SLOJ070 / S007
.SUBCKT TL082    1 2 3 4 5
*
  C1   11 12 3.498E-12
  C2    6  7 15.00E-12
  DC    5 53 DX
  DE   54  5 DX
  DLP  90 91 DX
  DLN  92 90 DX
  DP    4  3 DX
  EGND 99  0 POLY(2) (3,0) (4,0) 0 .5 .5
  FB    7 99 POLY(5) VB VC VE VLP VLN 0 4.715E6 -5E6 5E6 5E6 -5E6
  GA    6  0 11 12 282.8E-6
  GCM   0  6 10 99 8.942E-9
  ISS   3 10 DC 195.0E-6
  HLIM 90  0 VLIM 1K
  J1   11  2 10 JX
  J2   12  1 10 JX
  R2    6  9 100.0E3
  RD1   4 11 3.536E3
  RD2   4 12 3.536E3
  RO1   8  5 150
  RO2   7 99 150
  RP    3  4 2.143E3
  RSS  10 99 1.026E6
  VB    9  0 DC 0
  VC    3 53 DC 2.200
  VE   54  4 DC 2.200
  VLIM  7  8 DC 0
  VLP  91  0 DC 25
  VLN   0 92 DC 25
.MODEL DX D(IS=800.0E-18)
.MODEL JX PJF(IS=15.00E-12 BETA=270.1E-6 VTO=-1)
.ENDS
* model provenance: vendor=project approximation; part=2N7000 APPROX sim-only; file=../models/APPROX_2N7000.lib; sha256=081054dff4a75cb511fef93cd2e8c4310a685018b570eb92f2f241bc9b992a55; source=local APPROX; not manufacturer model
.SUBCKT APPROX_2N7000 D G S
M1 D G S S NMOS2N7000
.MODEL NMOS2N7000 NMOS (VTO=2.1 KP=0.05 LAMBDA=0.02 RD=1 RS=1 CBD=20p CBS=20p IS=1e-14)
* Body diode D-S behavior is critical in OCD topology; this approximation is rough.
DBODY S D DBODY2N7
.MODEL DBODY2N7 D (IS=1e-9 N=1.6 RS=0.5 CJO=20p)
.ENDS APPROX_2N7000
* model provenance: vendor=project approximation; part=1N34A Ge APPROX sim-only (S002-confirmed D1 type); file=../models/APPROX_1N34A.lib; sha256=db949f2074c80243651fc2ab6c003f27fecc0fba127df704fcdba44427450aaa; source=local APPROX; not manufacturer model; D1 per S002 C027
.MODEL APPROX_1N34A D (IS=2.58u RS=1n N=1.61 BV=60 IBV=1u CJO=0.8p)

* --- circuit ---
V1 VCC 0 DC 9
V_IN IN 0 SIN(0 50m 1k)
R1 VCC VCC_F 100
C2 VCC_F 0 10u
C3 VCC_F 0 100n
R4 VCC_F VREF 10k
R7 VREF 0 10k
C5 VREF 0 10u
C1 IN IN_B 22n
R2 IN_B 0 1Meg
R6 IN_B VREF 470k
R3 IN_B X1_P 10k
XX1A X1_P X1_FB VCC_F 0 X1_OUT TL082
R5 X1_FB VREF 2.2k
R8 X1_FB X2_W 18k
R_X2POT X2_W X1_OUT 500k
C4 X1_FB VREF 100n
C6 X1_OUT X1_FB 220p
R9 X1_OUT CLIP_A 10k
C7 VREF CLIP_A 10n
R10 CLIP_A CLIP_B 10k
R12 VREF CLIP_B 220k
XM1 VREF VREF CLIP_A APPROX_2N7000
XM2 VREF M2_D1_NODE M2_D1_NODE APPROX_2N7000
D1 CLIP_A M2_D1_NODE APPROX_1N34A
XX3A CLIP_B X3_FB VCC_F 0 X3_OUT TL082
R11 X3_FB VREF 39k
R13 X3_FB X3_OUT 150k
C8 X3_FB VREF 100n
C9 X3_OUT X3_FB 220p
C10 X3_OUT TONE_TOP 10u
R_X4A TONE_TOP TONE_W 5k
R_X4B TONE_W 0 5k
C11 TONE_W 0 47n
R14 TONE_W VOL_TOP 22k
R15 TONE_W VOL_TOP 33k
R_VOL5A VOL_TOP OUT 50k
R_VOL5B OUT 0 50k
R_LOAD OUT 0 100k

* --- analyses ---
.op
.dc V1 8 18 1
.tran 10u 30m
.ac dec 100 20 20k

.end
